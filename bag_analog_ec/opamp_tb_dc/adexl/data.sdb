ADE simulation setup
Run mode: Single Run, Sweeps and Corners
Tests:
  tb_dc: bag_analog_ec/opamp_tb_dc/schematic, simulator spectre
Global variables:
  vdd = 1
  vindc = 0.5
  vout = 0.5
  vmax = 0.9
  num_pts = 100
  gain_fb = 200
